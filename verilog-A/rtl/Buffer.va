`include "constants.vams"
`include "disciplines.vams"

// Behavioral buffer with a polynomial transfer characteristic.
// The default coefficients match the MATLAB expression:
// polyval(fliplr([0 0.6 0 0.4]), Vin) = 0.6*Vin + 0.4*Vin^3.
module Buffer(vin, vout);
	parameter real a0 = 0.0; // Constant coefficient.
	parameter real a1 = 0.6; // Linear coefficient.
	parameter real a2 = 0.0; // Quadratic coefficient.
	parameter real a3 = 0.4; // Cubic coefficient.

	input vin;               // Analog input voltage.
	output vout;             // Nonlinear buffered output voltage.
	electrical vin, vout;

	real vin_value;
	real buffer_voltage;

	analog begin
		vin_value = V(vin);

		// Evaluate the polynomial in ascending coefficient order,
		// matching MATLAB's polyval(fliplr(non_lin_parameters), Vin).
		buffer_voltage = a0 + a1 * vin_value +
			 a2 * vin_value * vin_value +
			 a3 * vin_value * vin_value * vin_value;

		V(vout) <+ buffer_voltage;
	end
endmodule
