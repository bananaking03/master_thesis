`include "constants.vams"
`include "disciplines.vams"

module DAC_un(ctrl, sample_clk, Vref, gnd, enable, vout);

    parameter integer N_BITS = 4;

    parameter real vlogic_threshold = 0.9;
    parameter real vclk_threshold = 0.5;
    parameter real Rdrive = 1k;

    input [1023:0] ctrl;
    input sample_clk;
    input Vref;
    input gnd;
    input enable;
    inout vout;

    electrical [1023:0] ctrl;
    electrical sample_clk;
    electrical Vref;
    electrical gnd;
    electrical enable;
    electrical vout;

    real dac_code;
    real vout_target;
    real unit_on [0:1023];
	real Vsample;

    integer i;
    genvar unit;

    // Convert each analog control input into a 0/1 value
    generate
        for (unit = 0; unit < (1 << N_BITS); unit = unit + 1) begin : gen_unit

            analog begin
                unit_on[unit] =
                    (V(ctrl[unit],gnd) >= vlogic_threshold) ? 1.0 : 0.0;
            end

        end
    endgenerate

    analog begin

        // Calculate DAC code
        dac_code = 0.0;

        for (i = 0; i < (1 << N_BITS); i = i + 1)
            dac_code = dac_code + unit_on[i];

        // Calculate target voltage
        vout_target =
            Vsample + dac_code * V(Vref,gnd) / (1 << N_BITS);

        // Drive phase
        if (V(sample_clk,gnd) < vclk_threshold) begin

            // Current flows from Vout toward the target
            I(vout,gnd) <+
                (V(vout,gnd) - vout_target) / Rdrive;

        end

        // Sampling / hold phase
        else begin

			Vsample = V(vout,gnd);

            // High impedance
            I(vout,gnd) <+ 0.0;

        end

    end

endmodule
