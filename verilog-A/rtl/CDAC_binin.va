`include "constants.vams"
`include "disciplines.vams"

module DAC_un_13b_binin(Sgnd, Vref, gnd, vout);

    parameter real vlogic_threshold = 0.9;
    parameter real Rdrive = 1k;

    input [12:0] Sgnd;
    inout Vref;
    inout gnd;
    inout vout;

    electrical [12:0] Sgnd;
    electrical Vref;
    electrical gnd;
    electrical vout;

    integer dac_code;
    integer bit_value [0:13];

    real vout_target;
    real Vsample;

    integer i;
    genvar bit_idx;

    // Read the electrical input bits
    generate
        for (bit_idx = 0; bit_idx < 14; bit_idx = bit_idx + 1) begin : gen_bits
            analog begin
                bit_value[bit_idx] =
                    (V(Sgnd[bit_idx], gnd) < vlogic_threshold) ? 1 : 0;
            end
        end
    endgenerate

    analog begin
        @(initial_step)
            Vsample = V(vout, gnd);

        // Convert binary input to integer
        dac_code = 0;

        for (i = 0; i < 14; i = i + 1) begin
            dac_code = dac_code + bit_value[i] * (1 << i);
        end

        // Calculate DAC output voltage
        vout_target =
            Vsample + dac_code * V(Vref, gnd) / 8192.0;

        // Sample input when DAC code is zero
        if (dac_code == 0) begin
            Vsample = V(vout, gnd);
            I(vout, gnd) <+ 0.0;
        end else begin
            I(vout, gnd) <+
                (V(vout, gnd) - vout_target) / Rdrive;
        end
    end

endmodule
